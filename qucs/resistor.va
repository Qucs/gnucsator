`include "discipline.h"
`define P(x) (*x*)

module RESISTOR(p,n);
	inout p,n;
	electrical p,n;

	parameter real R = 1k `P(info="Resistance" type="instance");

	real i (*ask="yes"*);
	real v (*ask="yes"*);
	analog begin
		i = I(p,n);
		v = V(p,n);
		V(p,n) <+ i * R;
	end
endmodule
